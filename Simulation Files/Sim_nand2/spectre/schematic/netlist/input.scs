// Design: CE391Lab1/Sim_nand2
simulator lang=spectre
global 0
parameters vdd=1.1
include "/vol/eecs391/FreePDK45/ncsu_basekit/models/hspice/hspice_nom.include"

// CE391Lab1/nand2/schematic
subckt nand2 A B gnd out vdd
    M1 (out B vdd vdd) PMOS_VTG w=600n l=50n ld=105n ls=105n m=1
    M0 (out A vdd vdd) PMOS_VTG w=600n l=50n ld=105n ls=105n m=1
    M3 (net014 B gnd gnd) NMOS_VTG w=800n l=50n ld=105n ls=105n m=1
    M2 (out A net014 gnd) NMOS_VTG w=800n l=50n ld=105n ls=105n m=1
ends nand2

// CE391Lab1/inverter/schematic
subckt inverter gnd in out vdd
    M1 (out in gnd gnd) NMOS_VTG w=400n l=50n ld=105n ls=105n m=1
    M0 (out in vdd vdd) PMOS_VTG w=600n l=50n ld=105n ls=105n m=1
ends inverter

// CE391Lab1/Sim_nand2/schematic
I0 (A B gnd out vdd) nand2
I6 (gnd out net26 vdd) inverter
I5 (gnd out net27 vdd) inverter
I4 (gnd out net28 vdd) inverter
I3 (gnd out net29 vdd) inverter
I2 (gnd net05 B vdd) inverter
I1 (gnd net10 A vdd) inverter
V1 (gnd 0) vsource dc=0 type=dc
V0 (vdd 0) vsource dc=vdd type=dc
V3 (net05 gnd) vsource type=pulse val0=0 val1=1.1 period=5n delay=1n rise=20p fall=20p width=2.5n
V2 (net10 gnd) vsource dc=0 type=pulse val0=0 val1=1.1 period=10n delay=1n rise=20p fall=20p width=5n
simulatorOptions options temp=27
tran tran stop=40n errpreset=moderate
save A B I0:5 out
