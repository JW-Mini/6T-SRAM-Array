// Design: CE391Lab1/Sim_inv
simulator lang=spectre
global 0
parameters vdd=1.1
include "/vol/eecs391/FreePDK45/ncsu_basekit/models/hspice/hspice_nom.include"

// CE391Lab1/inverter/schematic
subckt inverter gnd in out vdd
    M1 (out in gnd gnd) NMOS_VTG w=400n l=50n ld=105n ls=105n m=1
    M0 (out in vdd vdd) PMOS_VTG w=600n l=50n ld=105n ls=105n m=1
ends inverter

// CE391Lab1/Sim_inv/schematic
I4 (gnd out net06 vdd) inverter
I3 (gnd out net07 vdd) inverter
I2 (gnd out net08 vdd) inverter
I1 (gnd in out vdd) inverter
I0 (gnd net5 in vdd) inverter
V0 (net5 gnd) vsource dc=0 type=pulse val0=0 val1=1.1 period=10n delay=1n rise=20p fall=20p width=5n
V2 (gnd 0) vsource dc=0 type=dc
V1 (vdd 0) vsource dc=vdd type=dc
simulatorOptions options temp=27
tran tran stop=50n errpreset=moderate start=0n step=5n
save in I1:4
